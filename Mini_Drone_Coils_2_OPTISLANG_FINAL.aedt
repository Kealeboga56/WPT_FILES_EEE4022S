# Ansys Electronics Desktop project, version 2020.2
project datasets:
  $Thermal_conductivity_with_temperature_393: (19.85, 0.998581) (25.41, 1.00225) (30.96, 1.00644) (36.52, 1.01011) (42.07, 1.01431) (47.63, 1.01798) (53.18, 1.02217) (58.74, 1.02584) (64.29, 1.03003) (69.85, 1.0337)
materials:
  air: permittivity=1.0006 permeability=1.0000004
  copper: permeability=0.999991 conductivity=58000000
  vacuum: permittivity=1
  epoxy_Kevlar_xy: permittivity=3.6
  ferrite_3C90: core_loss_curve{25kHz (0, 0) (0.1, 10) (0.14, 20) (0.16, 30) (0.17, 40) (0.18, 50) (0.2, 60) (0.205, 70) (0.21, 80) (0.22, 90) (0.23, 100) (0.3, 300)} core_loss_curve{50kHz (0, 0) (0.09, 20) (0.1, 28) (0.12, 40) (0.14, 50) (0.15, 60) (0.155, 70) (0.16, 80) (0.165, 90) (0.17, 100) (0.2, 190) (0.24, 300) (0.26, 400) (0.3, 500)} core_loss_curve{85kHz (0, 0) (0.05, 10) (0.07, 20) (0.08, 30) (0.09, 40) (0.1, 50) (0.105, 60) (0.11, 70) (0.12, 90) (0.13, 100) (0.16, 200) (0.19, 300) (0.2, 350) (0.21, 400) (0.23, 500) (0.25, 600) (0.26, 700) (0.27, 800) (0.28, 900) (0.29, 1000) (0.3, 1100)} core_loss_curve{100kHz (0, 0) (0.062, 20) (0.07, 27) (0.072, 30) (0.08, 40) (0.09, 50) (0.092, 60) (0.1, 70) (0.105, 80) (0.11, 90) (0.12, 100) (0.16, 200) (0.18, 300) (0.19, 400) (0.2, 500) (0.22, 600) (0.23, 700) (0.25, 800) (0.26, 900) (0.27, 1000)} permittivity=12 permeability=2500 conductivity=0.01 core_loss_type="Power Ferrite" core_loss_cm=3.7059396 core_loss_x=1.3958618 core_loss_y=2.719196 mass_density=4800 core_loss_equiv_cut_depth=0.001meter
  Plastic, Acrylic (PMMA): permittivity=3.29848 conductivity=1.00484e-16 dielectric_loss_tangent=0.0547723

design EEE4022S_Coil_DESIGN (Maxwell 3D, EddyCurrent, model units mm)
variables:
  length = 180mm
  bend_radius = ((length/2)-dx)
  width = wire_diameter*number_turns
  height = wire_diameter*number_layers
  wire_diameter = 3.4mm
  number_turns = 23
  number_layers = 1
  number_conductors = number_turns*number_layers
  Rx_length = 87.5mm
  Rx_bend_radius = 18.1mm
  rx_width = rx_wire_diameter*rx_number_turns
  rx_height = rx_wire_diameter*rx_number_layers
  z_dist = 18.5mm
  rx_number_conductors = rx_number_turns*rx_number_layers
  rx_number_turns = 1
  rx_number_layers = 2
  y_dist = 0mm
  rx_wire_diameter = 3mm
  dx = 1mm
  rotation_angle = 60deg
  z_ferrite_move = 25mm
  block_dist = -17
  perspex_dist = 8mm
  px = 1mm
geometry:
  Polyline1 = polyline((length/2-bend_radius, -length/2, 0mm) (-(length/2-bend_radius), -length/2, 0mm))
  Polyline2 = polyline(z=0mm, xy: (-(length/2-bend_radius), -(length/2)) (-63.932504mm, -63.932504mm) (-90mm, -1mm), AngularArc from point 0 over 3 centre=(-(length/2-bend_radius), -(length/2-bend_radius), 0mm) angle=-90deg plane=XY)
  Polyline3 = polyline((-length/2, -(length/2-bend_radius), 0mm) (-length/2, (length/2-bend_radius), 0mm))
  Polyline4 = polyline(z=0mm, xy: (-(length/2), (length/2-bend_radius)) (-63.932504mm, 63.932504mm) (-1mm, 90mm), AngularArc from point 0 over 3 centre=(-(length/2-bend_radius), (length/2-bend_radius), 0mm) angle=-90deg plane=XY)
  Polyline5 = polyline((-(length/2-bend_radius), length/2, 0mm) ((length/2-bend_radius), length/2, 0mm))
  Polyline6 = polyline(z=0mm, xy: ((length/2-bend_radius), (length/2)) (63.932504mm, 63.932504mm) (90mm, 1mm), AngularArc from point 0 over 3 centre=((length/2-bend_radius), (length/2-bend_radius), 0mm) angle=-90deg plane=XY)
  Polyline7 = polyline((length/2, (length/2-bend_radius), 0mm) (length/2, -(length/2-bend_radius), 0mm))
  Polyline8 = polyline(z=0mm, xy: (length/2, -(length/2-bend_radius)) (63.932504mm, -63.932504mm) (1mm, -90mm), AngularArc from point 0 over 3 centre=(length/2-bend_radius, -(length/2-bend_radius), 0mm) angle=-90deg plane=XY)
  Tx_coil [copper] = rectangle(corner=(0mm, -length/2, 0mm), y_size=width, z_size=height)
  Polyline1.unite(Polyline2..Polyline8)
  Tx_coil.sweep_along_path(Polyline1)
  Rectangle1_Section1 = Tx_coil.section(plane=YZ)
  Rectangle1_Section1_Separate1 = Rectangle1_Section1.separate_bodies()
  Rectangle1_Section1.delete()
  Region [air] = region(percentage_offset=400 on all sides)
  Rx_coil [copper] = rectangle(corner=(0mm, -Rx_length/2, 0mm), y_size=rx_width, z_size=rx_height)
  Polyline9 = polyline((Rx_length/2-Rx_bend_radius, -Rx_length/2, 0mm) (-(Rx_length/2-Rx_bend_radius), -Rx_length/2, 0mm))
  Polyline10 = polyline(z=0mm, xy: (-(Rx_length/2-Rx_bend_radius), -(Rx_length/2)) (-38.448633mm, -38.448633mm) (-43.75mm, -25.65mm), AngularArc from point 0 over 3 centre=(-(Rx_length/2-Rx_bend_radius), -(Rx_length/2-Rx_bend_radius), 0mm) angle=-90deg plane=XY)
  Polyline11 = polyline((-Rx_length/2, -(Rx_length/2-Rx_bend_radius), 0mm) (-Rx_length/2, (Rx_length/2-Rx_bend_radius), 0mm))
  Polyline12 = polyline(z=0mm, xy: (-(Rx_length/2), (Rx_length/2-Rx_bend_radius)) (-38.448633mm, 38.448633mm) (-25.65mm, 43.75mm), AngularArc from point 0 over 3 centre=(-(Rx_length/2-Rx_bend_radius), (Rx_length/2-Rx_bend_radius), 0mm) angle=-90deg plane=XY)
  Polyline13 = polyline((-(Rx_length/2-Rx_bend_radius), Rx_length/2, 0mm) ((Rx_length/2-Rx_bend_radius), Rx_length/2, 0mm))
  Polyline14 = polyline(z=0mm, xy: ((Rx_length/2-Rx_bend_radius), (Rx_length/2)) (38.448633mm, 38.448633mm) (43.75mm, 25.65mm), AngularArc from point 0 over 3 centre=((Rx_length/2-Rx_bend_radius), (Rx_length/2-Rx_bend_radius), 0mm) angle=-90deg plane=XY)
  Polyline15 = polyline((Rx_length/2, (Rx_length/2-Rx_bend_radius), 0mm) (Rx_length/2, -(Rx_length/2-Rx_bend_radius), 0mm))
  Polyline16 = polyline(z=0mm, xy: (Rx_length/2, -(Rx_length/2-Rx_bend_radius)) (38.448633mm, -38.448633mm) (25.65mm, -43.75mm), AngularArc from point 0 over 3 centre=(Rx_length/2-Rx_bend_radius, -(Rx_length/2-Rx_bend_radius), 0mm) angle=-90deg plane=XY)
  Polyline9.unite(Polyline10..Polyline16)
  Rx_coil.sweep_along_path(Polyline9)
  Rectangle1_Section2 = Rx_coil.section(plane=YZ)
  Rectangle1_Section1_Separate2 = Rectangle1_Section2.separate_bodies()
  Rectangle1_Section2.delete()
  [Rx_coil, Rectangle1_Section1_Separate2].move(0mm, y_dist, z_dist)
  FerriteBlock_Master5 [ferrite_3C90] = box(corner=(-60mm, (-60+block_dist) mm, (-(7+7)+1.9) mm), size=(37mm, 102mm, 7mm))
  FerriteBlock_Master5.move(42mm, 103mm, 5mm)
  FerriteBlock_Master5.move(0mm, 8.2115242mm, -25mm)
  FerriteBlock_Master5.move(0mm, 0.78847577mm, 0.1mm)
  FerriteBlock_Master5.rotate(axis=Z, angle=rotation_angle*5)
  FerriteBlock_Master4 = box(corner=(-60mm, (-60+block_dist) mm, (-14+1.9) mm), size=(37mm, 102mm, 7mm))
  FerriteBlock_Master4.move(42mm, 103mm, 5mm)
  FerriteBlock_Master4.move(0mm, 8.2115242mm, -25mm)
  FerriteBlock_Master4.move(0mm, 0.78847577mm, 0.1mm)
  FerriteBlock_Master4.rotate(axis=Z, angle=rotation_angle*4)
  FerriteBlock_Master3 = box(corner=(-60mm, (-60+block_dist) mm, (-(7+7)+1.9) mm), size=(37mm, 102mm, 7mm))
  FerriteBlock_Master3.move(42mm, 103mm, 5mm)
  FerriteBlock_Master3.move(0mm, 8.2115242mm, -25mm)
  FerriteBlock_Master3.move(0mm, 0.78847577mm, 0.1mm)
  FerriteBlock_Master3.rotate(axis=Z, angle=rotation_angle*3)
  FerriteBlock_Master2 = box(corner=(-60mm, (-60+block_dist) mm, (-(7+7)+1.9) mm), size=(37mm, 102mm, 7mm))
  FerriteBlock_Master2.move(42mm, 103mm, 5mm)
  FerriteBlock_Master2.move(0mm, 8.2115242mm, -25mm)
  FerriteBlock_Master2.move(0mm, 0.78847577mm, 0.1mm)
  FerriteBlock_Master2.rotate(axis=Z, angle=rotation_angle*2)
  FerriteBlock_Master1 = box(corner=(-60mm, (-60+block_dist) mm, (-(7+7)+1.9) mm), size=(37mm, 102mm, 7mm))
  FerriteBlock_Master1.move(42mm, 103mm, 5mm)
  FerriteBlock_Master1.move(0mm, 8.2115242mm, -25mm)
  FerriteBlock_Master1.move(0mm, 0.78847577mm, 0.1mm)
  FerriteBlock_Master1.rotate(axis=Z, angle=rotation_angle)
  FerriteBlock_Master = box(corner=(-60mm, (-60+block_dist) mm, (-(7+7)+1.9) mm), size=(37mm, 102mm, 7mm))
  FerriteBlock_Master.move(42mm, 103mm, 5mm)
  FerriteBlock_Master.move(0mm, 8.2115242mm, -25mm)
  FerriteBlock_Master.move(0mm, 0.78847577mm, 0.1mm)
  FerriteBlock_Master5.unite(FerriteBlock_Master4, FerriteBlock_Master3, FerriteBlock_Master2, FerriteBlock_Master1, FerriteBlock_Master)
  FerriteBlock_Master5.move(0.0006165898mm, 0.045517328mm, z_ferrite_move)
  Top_perspex [Plastic, Acrylic (PMMA)] = box(corner=(160mm, -160mm, 0mm), size=(-320mm, 320mm, -3mm))
  Top_perspex.move(0mm, 0mm, perspex_dist)
  Bottom_perspex [Plastic, Acrylic (PMMA)] = box(corner=(160mm, -160mm, 0mm), size=(-320mm, 320mm, -3mm))
  Bottom_perspex.move(0mm, 0mm, -(perspex_dist-px))
boundaries and excitations:
  CoilTerminal1: Coil Terminal Objects=Rectangle1_Section1_Separate1 Conductor_number=number_conductors Winding=Tx_windings Point_out_of_terminal=false
  CoilTerminal2: Coil Terminal Objects=Rectangle1_Section1_Separate2 Conductor_number=rx_number_conductors Winding=Rx_windings Point_out_of_terminal=false
  Tx_windings: Winding Group Type=Current IsSolid=false Current=5A ParallelBranchesNum=1 Phase=0deg
  Rx_windings: Winding Group Type=Current IsSolid=false Current=5A ParallelBranchesNum=1 Phase=90deg
  eddy effects on: Tx_coil, Rx_coil
parameters:
  Matrix1: Matrix Rx_windings, Tx_windings:
mesh:
  Coils: LengthBased Objects=[Rx_coil, Tx_coil] NumMaxElem=2000
  Region: LengthBased RefineInside Objects=Region NumMaxElem=1000
  initial mesh: GlobalCurvilinear{Apply}
setups:
  Setup1: EddyCurrent MaximumPasses=10 MinimumPasses=10 MinimumConvergedPasses=1 PercentRefinement=30 PercentError=1 NonLinearResidual=0.0001 Frequency=85kHz
optimetrics:
  ParametricSetup1: Parametric disabled Sim._Setups=[Setup1]
    sweep z_dist: LIN 20mm 70mm 5mm
    sweep y_dist: LIN 0mm 100mm 20mm
output variables:
  coupling_k = CplCoef(Tx_windings,Rx_windings)
  k_value = Matrix1.CplCoef(Tx_windings,Rx_windings)
  Rx_volume = Volume(Rx_coil)
  Rx_inductance = L(Rx_windings,Rx_windings)
  Tx_inductance = L(Tx_windings,Tx_windings)
  Rx_resistance = R(Rx_windings,Rx_windings)
  Tx_resistance = R(Tx_windings,Tx_windings)
reports:
  coupling_table: coupling_k vs Freq on Setup1 : LastAdaptive [z_dist=all]
  Inductance_table: Rx_inductance, Tx_inductance vs Freq on Setup1 : LastAdaptive [z_dist=all]
  volume_table: Rx_volume vs Freq on Setup1 : LastAdaptive [z_dist=all]
  Resistance_table: Rx_resistance, Tx_resistance vs Freq on Setup1 : LastAdaptive [z_dist=all]
